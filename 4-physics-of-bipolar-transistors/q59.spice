Physics of Bipolar Transistors - Question 59

VIN in 0 DC 1
VCC1 cc1 0 2.5
VCC2 cc2 0 2.5

Q1 cc1 in 0 0 bjt

Q2 cc2 in emitter 0 bjt
Q3 emitter emitter 0 0 bjt

.model bjt NPN(BF=100, IS=0.5f, VAF=5)

.control
dc VIN 0 1.8 1m
plot -i(VCC1)
plot -i(VCC2)
.endc

.end
